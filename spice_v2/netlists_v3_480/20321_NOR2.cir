* Auto-generated by spice_v2/generate_spice_dataset.py
* sample_id=20321 cell=NOR2 corner=typical
.title NOR2 seed characterization sample 20321
.option method=gear reltol=1e-4 abstol=1e-12 vntol=1e-6
.temp 57.6042
.include "/Users/jiaqing/new_paper/gf180mcu-pdk/libraries/gf180mcu_fd_pr/latest/models/ngspice/design.ngspice"
.lib "/Users/jiaqing/new_paper/gf180mcu-pdk/libraries/gf180mcu_fd_pr/latest/models/ngspice/sm141064.ngspice" typical

VDD vdd 0 1.68485
Vin in 0 PULSE(0 1.68485 2.000000e-09 3.704067e-10 3.704067e-10 2.000000e-08 4.000000e-08)

Xn1 out in 0 0 nmos_3p3 W=3.34324u L=0.28u
Xn2 out in 0 0 nmos_3p3 W=3.34324u L=0.28u
Xp1 pmid in vdd vdd pmos_3p3 W=7.79258u L=0.28u
Xp2 out in pmid vdd pmos_3p3 W=7.79258u L=0.28u

Cload out 0 2.544651e-14

.tran 2p 1.200000e-07
.measure tran tphl TRIG v(in) VAL=0.842423 RISE=1 TARG v(out) VAL=0.842423 FALL=1
.measure tran tplh TRIG v(in) VAL=0.842423 FALL=1 TARG v(out) VAL=0.842423 RISE=1
.measure tran i_vdd_avg AVG i(VDD) FROM=5.000000e-09 TO=1.100000e-07
.measure tran power_avg_uW PARAM='-1.68485*i_vdd_avg*1e6'
.end
