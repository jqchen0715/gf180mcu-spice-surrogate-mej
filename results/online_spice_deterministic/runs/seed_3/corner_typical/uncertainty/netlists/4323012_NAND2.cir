* Auto-generated by spice_v2/generate_spice_dataset.py
* sample_id=4323012 cell=NAND2 corner=typical
.title NAND2 seed characterization sample 4323012
.option method=gear reltol=1e-4 abstol=1e-12 vntol=1e-6
.temp 64.4065
.include "gf180mcu-pdk/libraries/gf180mcu_fd_pr/latest/models/ngspice/design.ngspice"
.param sw_stat_global=0 sw_stat_mismatch=0
.lib "gf180mcu-pdk/libraries/gf180mcu_fd_pr/latest/models/ngspice/sm141064.ngspice" typical

VDD vdd 0 1.72839
Vin in 0 PULSE(0 1.72839 2.000000e-09 2.277952e-10 2.277952e-10 2.000000e-08 4.000000e-08)

Xn1 out in nmid 0 nmos_3p3 W=0.997099u L=0.28u
Xn2 nmid in 0 0 nmos_3p3 W=0.997099u L=0.28u
Xp1 out in vdd vdd pmos_3p3 W=2.93495u L=0.28u
Xp2 out in vdd vdd pmos_3p3 W=2.93495u L=0.28u

Cload out 0 8.573625e-14

.tran 2p 1.200000e-07
.measure tran tphl TRIG v(in) VAL=0.864194 RISE=1 TARG v(out) VAL=0.864194 FALL=1
.measure tran tplh TRIG v(in) VAL=0.864194 FALL=1 TARG v(out) VAL=0.864194 RISE=1
.measure tran i_vdd_avg AVG i(VDD) FROM=5.000000e-09 TO=1.100000e-07
.measure tran power_avg_uW PARAM='-1.72839*i_vdd_avg*1e6'
.end
