* Auto-generated by spice_v2/generate_spice_dataset.py
* sample_id=4421024 cell=XOR2 corner=typical
.title XOR2 seed characterization sample 4421024
.option method=gear reltol=1e-4 abstol=1e-12 vntol=1e-6
.temp -5.49625
.include "gf180mcu-pdk/libraries/gf180mcu_fd_pr/latest/models/ngspice/design.ngspice"
.param sw_stat_global=0 sw_stat_mismatch=0
.lib "gf180mcu-pdk/libraries/gf180mcu_fd_pr/latest/models/ngspice/sm141064.ngspice" typical

VDD vdd 0 1.78109
Vin in 0 PULSE(0 1.78109 2.000000e-09 1.943675e-10 1.943675e-10 2.000000e-08 4.000000e-08)
Vb b 0 1.78109

        * XOR2 A1->Z arc with A2 held at VDD:
        * out = in xor b, b = VDD. Internal inverters create abar and bbar.
Xna_inv abar in 0 0 nmos_3p3 W=0.797369u L=0.28u
Xpa_inv abar in vdd vdd pmos_3p3 W=1.6522u L=0.28u
Xnb_inv bbar b 0 0 nmos_3p3 W=0.797369u L=0.28u
Xpb_inv bbar b vdd vdd pmos_3p3 W=1.6522u L=0.28u
Xnpass_a out bbar in 0 nmos_3p3 W=0.996712u L=0.28u
Xppass_a out b in vdd pmos_3p3 W=2.06525u L=0.28u
Xnpass_abar out b abar 0 nmos_3p3 W=0.996712u L=0.28u
Xppass_abar out bbar abar vdd pmos_3p3 W=2.06525u L=0.28u

Cload out 0 3.667999e-14

.tran 2p 1.200000e-07
.measure tran tphl TRIG v(in) VAL=0.890546 RISE=1 TARG v(out) VAL=0.890546 FALL=1
.measure tran tplh TRIG v(in) VAL=0.890546 FALL=1 TARG v(out) VAL=0.890546 RISE=1
.measure tran i_vdd_avg AVG i(VDD) FROM=5.000000e-09 TO=1.100000e-07
.measure tran power_avg_uW PARAM='-1.78109*i_vdd_avg*1e6'
.end
