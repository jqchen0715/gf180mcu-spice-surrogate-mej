* SKY130 cross-PDK protocol-replication testbench
* sample_id=26500010 cell=nand3_4 source_cell=sky130_fd_sc_hd__nand3_4 corner=typical
.title SKY130 library cell nand3_4 A_to_Y__B=1,C=1
.option scale=1.0u method=gear reltol=1e-4 abstol=1e-12 vntol=1e-6
.temp -27.663568
.param mc_mm_switch=0 mc_pr_switch=0
.include "/Users/jiaqing/new_paper/sky130-pdk/libraries/sky130_fd_pr/latest/cells/nfet_01v8/sky130_fd_pr__nfet_01v8__tt.pm3.spice"
.include "/Users/jiaqing/new_paper/sky130-pdk/libraries/sky130_fd_pr/latest/cells/nfet_01v8/sky130_fd_pr__nfet_01v8__mismatch.corner.spice"
.include "/Users/jiaqing/new_paper/sky130-pdk/libraries/sky130_fd_pr/latest/cells/pfet_01v8_hvt/sky130_fd_pr__pfet_01v8_hvt__tt.pm3.spice"
.include "/Users/jiaqing/new_paper/sky130-pdk/libraries/sky130_fd_pr/latest/cells/pfet_01v8_hvt/sky130_fd_pr__pfet_01v8_hvt__mismatch.corner.spice"
.include "/Users/jiaqing/new_paper/sky130-pdk/libraries/sky130_fd_sc_hd/latest/cells/nand3/sky130_fd_sc_hd__nand3_4.spice"

VDD vdd 0 1.6319998
VIN a 0 PULSE(0 1.6319998 24n 8.6416005n 8.6416005n 70n 160n)
VFIX_B b 0 1.6319998
VFIX_C c 0 1.6319998
XU1 a b c 0 0 vdd vdd y sky130_fd_sc_hd__nand3_4
CLOAD y 0 0.076203099p

.tran 5p 340n
.measure tran tphl TRIG v(a) VAL=0.81599989 RISE=1 TARG v(y) VAL=0.81599989 FALL=1
.measure tran tplh TRIG v(a) VAL=0.81599989 FALL=1 TARG v(y) VAL=0.81599989 RISE=1
.measure tran i_vdd_avg AVG i(VDD) FROM=10n TO=330n
.measure tran power_avg_uW PARAM='-1.6319998*i_vdd_avg*1e6'
.end
