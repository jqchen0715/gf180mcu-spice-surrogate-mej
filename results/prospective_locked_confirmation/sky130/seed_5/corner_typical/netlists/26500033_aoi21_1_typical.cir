* SKY130 cross-PDK protocol-replication testbench
* sample_id=26500033 cell=aoi21_1 source_cell=sky130_fd_sc_hd__a21oi_1 corner=typical
.title SKY130 library cell aoi21_1 A1_to_Y__A2=1,B1=0
.option scale=1.0u method=gear reltol=1e-4 abstol=1e-12 vntol=1e-6
.temp -1.3098714
.param mc_mm_switch=0 mc_pr_switch=0
.include "/Users/jiaqing/new_paper/sky130-pdk/libraries/sky130_fd_pr/latest/cells/nfet_01v8/sky130_fd_pr__nfet_01v8__tt.pm3.spice"
.include "/Users/jiaqing/new_paper/sky130-pdk/libraries/sky130_fd_pr/latest/cells/nfet_01v8/sky130_fd_pr__nfet_01v8__mismatch.corner.spice"
.include "/Users/jiaqing/new_paper/sky130-pdk/libraries/sky130_fd_pr/latest/cells/pfet_01v8_hvt/sky130_fd_pr__pfet_01v8_hvt__tt.pm3.spice"
.include "/Users/jiaqing/new_paper/sky130-pdk/libraries/sky130_fd_pr/latest/cells/pfet_01v8_hvt/sky130_fd_pr__pfet_01v8_hvt__mismatch.corner.spice"
.include "/Users/jiaqing/new_paper/sky130-pdk/libraries/sky130_fd_sc_hd/latest/cells/a21oi/sky130_fd_sc_hd__a21oi_1.spice"

VDD vdd 0 1.9552676
VIN a1 0 PULSE(0 1.9552676 24n 0.33353487n 0.33353487n 70n 160n)
VFIX_A2 a2 0 1.9552676
VFIX_B1 b1 0 0
XU1 a1 a2 b1 0 0 vdd vdd y sky130_fd_sc_hd__a21oi_1
CLOAD y 0 0.087595151p

.tran 5p 340n
.measure tran tphl TRIG v(a1) VAL=0.9776338 RISE=1 TARG v(y) VAL=0.9776338 FALL=1
.measure tran tplh TRIG v(a1) VAL=0.9776338 FALL=1 TARG v(y) VAL=0.9776338 RISE=1
.measure tran i_vdd_avg AVG i(VDD) FROM=10n TO=330n
.measure tran power_avg_uW PARAM='-1.9552676*i_vdd_avg*1e6'
.end
