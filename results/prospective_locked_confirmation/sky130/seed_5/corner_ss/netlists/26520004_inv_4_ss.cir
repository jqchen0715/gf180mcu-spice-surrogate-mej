* SKY130 cross-PDK protocol-replication testbench
* sample_id=26520004 cell=inv_4 source_cell=sky130_fd_sc_hd__inv_4 corner=ss
.title SKY130 library cell inv_4 A_to_Y
.option scale=1.0u method=gear reltol=1e-4 abstol=1e-12 vntol=1e-6
.temp -33.839663
.param mc_mm_switch=0 mc_pr_switch=0
.include "/Users/jiaqing/new_paper/sky130-pdk/libraries/sky130_fd_pr/latest/cells/nfet_01v8/sky130_fd_pr__nfet_01v8__ss.pm3.spice"
.include "/Users/jiaqing/new_paper/sky130-pdk/libraries/sky130_fd_pr/latest/cells/nfet_01v8/sky130_fd_pr__nfet_01v8__mismatch.corner.spice"
.include "/Users/jiaqing/new_paper/sky130-pdk/libraries/sky130_fd_pr/latest/cells/pfet_01v8_hvt/sky130_fd_pr__pfet_01v8_hvt__ss.pm3.spice"
.include "/Users/jiaqing/new_paper/sky130-pdk/libraries/sky130_fd_pr/latest/cells/pfet_01v8_hvt/sky130_fd_pr__pfet_01v8_hvt__mismatch.corner.spice"
.include "/Users/jiaqing/new_paper/sky130-pdk/libraries/sky130_fd_sc_hd/latest/cells/inv/sky130_fd_sc_hd__inv_4.spice"

VDD vdd 0 1.7254071
VIN a 0 PULSE(0 1.7254071 24n 2.8960117n 2.8960117n 70n 160n)

XU1 a 0 0 vdd vdd y sky130_fd_sc_hd__inv_4
CLOAD y 0 0.031669725p

.tran 5p 340n
.measure tran tphl TRIG v(a) VAL=0.86270355 RISE=1 TARG v(y) VAL=0.86270355 FALL=1
.measure tran tplh TRIG v(a) VAL=0.86270355 FALL=1 TARG v(y) VAL=0.86270355 RISE=1
.measure tran i_vdd_avg AVG i(VDD) FROM=10n TO=330n
.measure tran power_avg_uW PARAM='-1.7254071*i_vdd_avg*1e6'
.end
