* Released GF180MCU 7-track CDL external-validation testbench
* sample_id=8000532 cell=nand3_1 arc=A1_to_ZN__A2=1,A3=1 corner=ff
.title GF180MCU library cell nand3_1 A1_to_ZN__A2=1,A3=1
.option method=gear reltol=1e-4 abstol=1e-12 vntol=1e-6
.temp 3.7189644
.include "design.ngspice"
.param sw_stat_global=0 sw_stat_mismatch=0
.lib "sm141064.ngspice" ff

* Copyright 2022 GlobalFoundries PDK Authors
*
* Licensed under the Apache License, Version 2.0 (the "License");
* you may not use this file except in compliance with the License.
* You may obtain a copy of the License at
*
*      http://www.apache.org/licenses/LICENSE-2.0
*
* Unless required by applicable law or agreed to in writing, software
* distributed under the License is distributed on an "AS IS" BASIS,
* WITHOUT WARRANTIES OR CONDITIONS OF ANY KIND, either express or implied.
* See the License for the specific language governing permissions and
* limitations under the License.

.SUBCKT gf180mcu_fd_sc_mcu7t5v0__nand3_1 A1 A2 A3 ZN VDD VNW VPW VSS
X_i_2 net_1 A3 VSS VPW nmos_6p0 W=8.2e-07 L=6e-07
X_i_1 net_0 A2 net_1 VPW nmos_6p0 W=8.2e-07 L=6e-07
X_i_0 ZN A1 net_0 VPW nmos_6p0 W=8.2e-07 L=6e-07
X_i_5 ZN A3 VDD VNW pmos_6p0 W=9.85e-07 L=5e-07
X_i_4 VDD A2 ZN VNW pmos_6p0 W=9.85e-07 L=5e-07
X_i_3 ZN A1 VDD VNW pmos_6p0 W=9.85e-07 L=5e-07
.ENDS

VDD vdd 0 1.8127504
VIN a1 0 PULSE(0 1.8127504 24.0n 0.14211328n 0.14211328n 70.0n 160.0n)
VFIX_A2 a2 0 1.8127504
VFIX_A3 a3 0 1.8127504
XU1 a1 a2 a3 zn vdd vdd 0 0 gf180mcu_fd_sc_mcu7t5v0__nand3_1
CLOAD zn 0 0.16794753p

.tran 5p 340.0n
.measure tran tphl TRIG v(a1) VAL=0.90637522 RISE=1 TARG v(zn) VAL=0.90637522 FALL=1
.measure tran tplh TRIG v(a1) VAL=0.90637522 FALL=1 TARG v(zn) VAL=0.90637522 RISE=1
.measure tran i_vdd_avg AVG i(VDD) FROM=10n TO=330n
.measure tran power_avg_uW PARAM='-1.8127504*i_vdd_avg*1e6'
.end
