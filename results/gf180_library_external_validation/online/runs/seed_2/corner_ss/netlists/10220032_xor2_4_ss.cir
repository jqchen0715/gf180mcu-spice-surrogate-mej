* Released GF180MCU 7-track CDL external-validation testbench
* sample_id=10220032 cell=xor2_4 arc=A1_to_Z__A2=0 corner=ss
.title GF180MCU library cell xor2_4 A1_to_Z__A2=0
.option method=gear reltol=1e-4 abstol=1e-12 vntol=1e-6
.temp 84.298856
.include "design.ngspice"
.param sw_stat_global=0 sw_stat_mismatch=0
.lib "sm141064.ngspice" ss

* Copyright 2022 GlobalFoundries PDK Authors
*
* Licensed under the Apache License, Version 2.0 (the "License");
* you may not use this file except in compliance with the License.
* You may obtain a copy of the License at
*
*      http://www.apache.org/licenses/LICENSE-2.0
*
* Unless required by applicable law or agreed to in writing, software
* distributed under the License is distributed on an "AS IS" BASIS,
* WITHOUT WARRANTIES OR CONDITIONS OF ANY KIND, either express or implied.
* See the License for the specific language governing permissions and
* limitations under the License.

.SUBCKT gf180mcu_fd_sc_mcu7t5v0__xor2_4 A1 A2 Z VDD VNW VPW VSS
X_i_8 net_2 A2 I VPW nmos_6p0 W=3.6e-07 L=6e-07
X_i_9 VSS A1 net_2 VPW nmos_6p0 W=3.6e-07 L=6e-07
X_i_4 net_0 I VSS VPW nmos_6p0 W=8.2e-07 L=6e-07
X_i_2 Z_neg A1 net_0 VPW nmos_6p0 W=8.2e-07 L=6e-07
X_i_3 net_0 A2 Z_neg VPW nmos_6p0 W=8.2e-07 L=6e-07
X_i_0_0 Z Z_neg VSS VPW nmos_6p0 W=8.2e-07 L=6e-07
X_i_0_1 VSS Z_neg Z VPW nmos_6p0 W=8.2e-07 L=6e-07
X_i_0_2 Z Z_neg VSS VPW nmos_6p0 W=8.2e-07 L=6e-07
X_i_0_3 VSS Z_neg Z VPW nmos_6p0 W=8.2e-07 L=6e-07
X_i_10 I A2 VDD VNW pmos_6p0 W=3.85e-07 L=5e-07
X_i_11 VDD A1 I VNW pmos_6p0 W=3.85e-07 L=5e-07
X_i_7 Z_neg I VDD VNW pmos_6p0 W=1.095e-06 L=5e-07
X_i_5 net_1 A1 Z_neg VNW pmos_6p0 W=1.095e-06 L=5e-07
X_i_6 VDD A2 net_1 VNW pmos_6p0 W=1.095e-06 L=5e-07
X_i_1_0 Z Z_neg VDD VNW pmos_6p0 W=1.22e-06 L=5e-07
X_i_1_1 VDD Z_neg Z VNW pmos_6p0 W=1.22e-06 L=5e-07
X_i_1_2 Z Z_neg VDD VNW pmos_6p0 W=1.22e-06 L=5e-07
X_i_1_3 VDD Z_neg Z VNW pmos_6p0 W=1.22e-06 L=5e-07
.ENDS

VDD vdd 0 1.6935225
VIN a1 0 PULSE(0 1.6935225 24.0n 2.0952391n 2.0952391n 70.0n 160.0n)
VFIX_A2 a2 0 0
XU1 a1 a2 z vdd vdd 0 0 gf180mcu_fd_sc_mcu7t5v0__xor2_4
CLOAD z 0 0.087403591p

.tran 5p 340.0n
.measure tran tplh TRIG v(a1) VAL=0.84676126 RISE=1 TARG v(z) VAL=0.84676126 RISE=1
.measure tran tphl TRIG v(a1) VAL=0.84676126 FALL=1 TARG v(z) VAL=0.84676126 FALL=1
.measure tran i_vdd_avg AVG i(VDD) FROM=10n TO=330n
.measure tran power_avg_uW PARAM='-1.6935225*i_vdd_avg*1e6'
.end
